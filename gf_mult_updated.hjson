// Copyright lowRISC contributors.
// Licensed under the Apache License, Version 2.0, see LICENSE for details.
// SPDX-License-Identifier: Apache-2.0

// viterbi reg 

{
    name: "viterbi",
    clock_primary: "clk_i",
    reset_primary: "rst_ni",
    bus_interfaces:[ 
        {
             protocol: "reg_iface",
             direction: "device"
         }
      ],

    regwidth: "32",
    registers: [
        {
            name: "dataX",
            desc: "DataX Input",
            swaccess: "wo",
            fields: [
                { bits: "7:0", name: "dataX", desc: "input parameter dataX"
                }
            ],
         
        },
        { 
            name: "dataY",
            desc: "DataY Input.",
            swaccess: "wo",
            fields: [
                { bits: "7:0", name: "dataY", desc: "input parameter dataY"
                }
            ],

        },
        { 
            name: "bitout",
            desc: "results",
            swaccess: "ro",
            hwaccess: "hwo",
            hwext: "true",
            fields: [
                { bits: "0", name: "bitout", desc: "output"
                }
            ],
        },
        { name: "CTRL1",
          desc: "Controls trigger signal of the gf arithmetic.",
          swaccess: "wo",
          hwaccess: "hro",
          hwext: "true",
          hwqe : "true",
          fields: [
              { bits: "0", name: "TRIGGER", desc: "Trigger operation on rising edge."
              }
             
          ]
        },
         { name: "Flush",
          desc: "Reset Viterbi.",
          swaccess: "wo",
          hwaccess: "hro",
          hwext: "true",
          hwqe : "true",
          fields: [
              { bits: "0", name: "TRIGGER", desc: "SW Reset."
              }
             
          ]
        },
        { name: "Valid_output",
          desc: "Tell if the Output is valid.",
          swaccess: "ro",
          hwaccess: "hwo",
          hwext: "true",
          fields: [ 
              { bits: "0", name: "Status", desc: "Valid Output",
         	  }
          ]
       },
    ],
}
